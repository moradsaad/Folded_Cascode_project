ADE simulation setup
Run mode: Single Run, Sweeps and Corners
Tests:
  folded_cascode_project:Mosfet_charecterisation:1: folded_cascode_project/Mosfet_charecterisation/schematic, simulator spectre
Global variables:
  L = 1.2u:200n:2.4u
  VBS = 0
  VDS = 0.7
  VGS = 1
  W = 2u
