ADE simulation setup
Run mode: Single Run, Sweeps and Corners
Tests:
  folded_cascode_project:Mosfet_charecterisation:1: folded_cascode_project/Mosfet_charecterisation/schematic, simulator spectre
    Outputs: cdd; getData("M0:ids" ?result "dc"); ids op; getData("M0:rout" ?result "dcOp"); gm; (getData("M0:gm" ?result "dcOp") * getData("M0:rout" ?result "dcOp")); rout Op; cgg P; gm PMos; ids PMos; vgs Vs. gm/id PMOS; ids Vs. gm/ids; gm*ro Vs gm/id PMOS; ft PMOS; rout Vs. vgs PMOS; rout op; vgs PMOS; Vdsat; Vdsat vs gm /id; Vdsat OP
Global variables:
  L = 1.7u
  VBS = 0.417
  VDS = 0.853
  VGS = 0.853
  W = 400n
