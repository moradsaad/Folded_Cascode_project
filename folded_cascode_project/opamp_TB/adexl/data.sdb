ADE simulation setup
Run mode: Single Run, Sweeps and Corners
Tests:
  folded_cascode_project:opamp_TB:1: folded_cascode_project/opamp_TB/schematic, simulator spectre
    Outputs: Aol_dB
Global variables:
  VB2 = 1.8
  VB3 = 1.27
  VICMAC = 0
  VIDAC = 0
  VIDDC = -0.1:1m:0.1
  u = 1
