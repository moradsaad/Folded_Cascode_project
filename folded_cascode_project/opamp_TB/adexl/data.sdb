ADE simulation setup
Run mode: Single Run, Sweeps and Corners
Tests:
  folded_cascode_project:opamp_TB:1: folded_cascode_project/opamp_TB/schematic, simulator spectre
    Outputs: Aol_dB
Global variables:
  VICMAC = 0
  VIDAC = 1
  VIDDC = 0
  u = 1
