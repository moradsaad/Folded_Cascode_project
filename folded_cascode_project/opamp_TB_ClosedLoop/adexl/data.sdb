ADE simulation setup
Run mode: Single Run, Sweeps and Corners
Tests:
  folded_cascode_project:opamp_TB_ClosedLoop:1: folded_cascode_project/opamp_TB_ClosedLoop/schematic, simulator spectre
    Outputs: Acl; SR
Global variables:
  VB2 = 1.73
  VB3 = 1.65
  Vincm = 1.65
  Vind = 1
