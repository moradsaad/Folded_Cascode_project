ADE simulation setup
Run mode: Single Run, Sweeps and Corners
Tests:
  folded_cascode_project:opamp_TB_ClosedLoop:1: folded_cascode_project/opamp_TB_ClosedLoop/schematic, simulator spectre
    Outputs: Acl; settlingTime(VT("/Vout") 1.5 nil 2 nil 4 nil "time"); settlingTime(VT("/Vout") 1.5 nil 2 nil 10 nil "time"); settlingTime(VT("/Vout") 1.5 nil 2 nil 100 nil "time"); settlingTime(VT("/Vout") 1.5 nil 2 nil 70 nil "time"); settlingTime(VT("/Vout") 1.5 nil 1.7 nil 2 nil "time"); settlingTime(VT("/Vout") 1.5 nil 2 nil 1 nil "time"); settlingTime(VT("/Vout") 1.5 nil 1.7 nil 1 nil "time"); settlingTime(VT("/Vout") 1.5 nil 1.6 nil 2 nil "time"); settlingTime(VT("/Vout") 1.5 nil 1.6 nil 1 nil "time"); settlingTime(VT("/Vout") 1 nil 2.4 nil 2 nil "time"); settlingTime(VT("/Vout") 1 nil 2.4 nil 1 nil "time"); slew rate
Global variables:
  VB2 = 1.8
  VB3 = 1.27
  Vincm = 1.65
  Vind = 1
